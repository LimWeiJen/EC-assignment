* C:\Users\Lim Wei Jen\Documents\UM Programming\latex template\EC assignment - New\pspice simulation\Circuit A.sch

* Schematics Version 9.1 - Web Update 1
* Thu May 07 21:23:38 2026

** Analysis setup **
.ac DEC 100 10 100Meg
.OP

* From [PSPICE NETLIST] section of pspiceev.ini:
.lib "nom.lib"

.INC "Circuit A.net"
.INC "Circuit A.als"

.probe

.END
