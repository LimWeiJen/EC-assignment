* C:\Users\Lim Wei Jen\Documents\UM Programming\latex template\EC assignment - New\pspice simulation\Circuit C.sch

* Schematics Version 9.1 - Web Update 1
* Thu May 07 22:01:27 2026

** Analysis setup **
.ac DEC 101 10 100Meg
.OP

* From [PSPICE NETLIST] section of pspiceev.ini:
.lib "nom.lib"

.INC "Circuit C.net"
.INC "Circuit C.als"

.probe

.END
