* C:\Users\Lim Wei Jen\Documents\UM Programming\latex template\EC assignment - New\pspice simulation\Circuit B.sch

* Schematics Version 9.1 - Web Update 1
* Thu May 14 18:21:29 2026

** Analysis setup **
.tran 10us 5ms 0 10us
.OP

* From [PSPICE NETLIST] section of pspiceev.ini:
.lib "nom.lib"

.INC "Circuit B.net"
.INC "Circuit B.als"

.probe

.END
